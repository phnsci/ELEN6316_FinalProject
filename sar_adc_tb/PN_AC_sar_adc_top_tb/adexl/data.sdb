ADE simulation setup
Run mode: Single Run, Sweeps and Corners
Tests:
  sar_adc_tb:PN_AC_sar_adc_top_tb:1: sar_adc_tb/PN_AC_sar_adc_top_tb/schematic, simulator spectre
Global variables:
  vhi = 1.8
  vlo = 0
  tcplhq = 5n
  tcphlq = 5n
  fmult = 12
  unit_cap = 50f,10p
  fsamp = 10k
  J = 127
  M = 2048
  tstart = 2n
  pts_per_symbol = 32
  tstop = 2n+M/(fsamp*J)
  flogic = fmult*fsamp
  _tstop = tstart+((M+10)/fsamp)
  tstep = 1/(pts_per_symbol*flogic)
